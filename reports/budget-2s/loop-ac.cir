Budget-2S open-loop small-signal model; study assumptions, no switching
VSTIM EXC 0 AC 1
GEA 0 COMP EXC 0 0.0013
RO COMP 0 769230.769231
RCOMP COMP CZ 180
CCOMP CZ 0 1e-06
CHF COMP 0 4.7e-09
EINNER CMD 0 COMP 0 1
RINNER CMD CMD_F 1000
CINNER CMD_F 0 3.9788735773e-09
GMOD 0 OUT CMD_F 0 21
COUT OUT 0 0.0001
RLOAD OUT 0 0.2
ESENSE RAW_CS 0 OUT 0 2.5
RSENSE RAW_CS CS_POLE 1000
CSENSE CS_POLE 0 4.30148494843e-09
EBUFFER CS_OUT 0 CS_POLE 0 1
RTOP CS_OUT FB 27400
RBOTTOM FB 0 10000
.control
set wr_vecnames
set wr_singlescale
ac dec 100 1 2000000
wrdata loop-ac.txt v(FB)
quit
.endc
.end
